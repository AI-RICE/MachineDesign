# Ansys Electronics Desktop project, version 2026.1
materials:
  vacuum: permittivity=1
  Cogent Power - M350-50A, B-H at 50Hz: core_loss_curve{50Hz (0, 0) (0.05, 0.01) (0.1, 0.02) (0.15, 0.055) (0.2, 0.09) (0.25, 0.135) (0.3, 0.18) (0.35, 0.24) (0.4, 0.3) (0.45, 0.37) (0.5, 0.44) (0.55, 0.515) (0.6, 0.59) (0.65, 0.675) (0.7, 0.76) (0.75, 0.855) (0.8, 0.95) (0.85, 1.055) (0.9, 1.16) (0.95, 1.275) (1, 1.39) (1.05, 1.52) (1.1, 1.65) (1.15, 1.8) (1.2, 1.95) (1.25, 2.12) (1.3, 2.29) (1.35, 2.52) (1.4, 2.75) (1.45, 3.02) (1.5, 3.29) (1.55, 3.85) (1.6, 4.41) (1.65, 4.59) (1.7, 4.77) (1.75, 4.885) (1.8, 5)} core_loss_curve{100Hz (0, 0) (0.05, 0.03) (0.1, 0.06) (0.15, 0.15) (0.2, 0.24) (0.25, 0.37) (0.3, 0.5) (0.35, 0.655) (0.4, 0.81) (0.45, 0.995) (0.5, 1.18) (0.55, 1.39) (0.6, 1.6) (0.65, 1.84) (0.7, 2.08) (0.75, 2.35) (0.8, 2.62) (0.85, 2.915) (0.9, 3.21) (0.95, 3.545) (1, 3.88) (1.05, 4.245) (1.1, 4.61) (1.15, 5.02) (1.2, 5.43) (1.25, 5.9) (1.3, 6.37) (1.35, 6.95) (1.4, 7.53) (1.45, 8.26) (1.5, 8.99) (1.55, 9.72) (1.6, 10.45) (1.65, 11.18) (1.7, 11.91) (1.75, 12.64) (1.8, 13.37)} core_loss_curve{200Hz (0, 0) (0.05, 0.085) (0.1, 0.17) (0.15, 0.395) (0.2, 0.62) (0.25, 0.96) (0.3, 1.3) (0.35, 1.725) (0.4, 2.15) (0.45, 2.66) (0.5, 3.17) (0.55, 3.765) (0.6, 4.36) (0.65, 5.045) (0.7, 5.73) (0.75, 6.52) (0.8, 7.31) (0.85, 8.2) (0.9, 9.09) (0.95, 10.095) (1, 11.1) (1.05, 12.25) (1.1, 13.4) (1.15, 14.7) (1.2, 16) (1.25, 17.45) (1.3, 18.9) (1.35, 20.6) (1.4, 22.3) (1.45, 24.45) (1.5, 26.6) (1.55, 28.75) (1.6, 30.9) (1.65, 33.05) (1.7, 35.2) (1.75, 37.35) (1.8, 39.5)} core_loss_curve{400Hz (0, 0) (0.05, 0.24) (0.1, 0.48) (0.15, 1.115) (0.2, 1.75) (0.25, 2.685) (0.3, 3.62) (0.35, 4.82) (0.4, 6.02) (0.45, 7.49) (0.5, 8.96) (0.55, 10.73) (0.6, 12.5) (0.65, 14.55) (0.7, 16.6) (0.75, 19.05) (0.8, 21.5) (0.85, 24.35) (0.9, 27.2) (0.95, 30.5) (1, 33.8) (1.05, 37.65) (1.1, 41.5) (1.15, 45.95) (1.2, 50.4) (1.25, 55.4) (1.3, 60.4) (1.35, 66.25) (1.4, 72.1) (1.45, 78.9) (1.5, 85.7) (1.55, 92.5) (1.6, 99.3) (1.65, 106.1) (1.7, 112.9) (1.75, 119.7) (1.8, 126.5)} core_loss_curve{1000Hz (0, 0) (0.05, 1.01) (0.1, 2.02) (0.15, 4.585) (0.2, 7.15) (0.25, 10.925) (0.3, 14.7) (0.35, 19.65) (0.4, 24.6) (0.45, 30.9) (0.5, 37.2) (0.55, 45.15) (0.6, 53.1) (0.65, 62.9) (0.7, 72.7) (0.75, 84.8) (0.8, 96.9) (0.85, 111.45) (0.9, 126) (0.95, 144) (1, 162) (1.05, 183) (1.1, 204) (1.15, 229) (1.2, 254) (1.25, 283) (1.3, 312) (1.35, 345) (1.4, 378) (1.45, 417) (1.5, 456) (1.55, 495) (1.6, 534) (1.65, 573) (1.7, 612) (1.75, 651) (1.8, 690)} permeability{HUnit=A_per_meter BUnit=tesla curve (0, 0) (9.03568, 0.025) (17.6854, 0.05) (25.5633, 0.075) (32.2833, 0.1) (37.5786, 0.125) (41.6583, 0.15) (44.8505, 0.175) (47.4833, 0.2) (49.8375, 0.225) (52.0042, 0.25) (54.0271, 0.275) (55.95, 0.3) (57.8115, 0.325) (59.6292, 0.35) (61.4156, 0.375) (63.1833, 0.4) (64.9438, 0.425) (66.7042, 0.45) (68.4708, 0.475) (70.25, 0.5) (72.0482, 0.525) (73.8729, 0.55) (75.732, 0.575) (77.6333, 0.6) (79.5841, 0.625) (81.5896, 0.65) (83.6544, 0.675) (85.7833, 0.7) (87.9826, 0.725) (90.2646, 0.75) (92.6435, 0.775) (95.1333, 0.8) (97.7531, 0.825) (100.542, 0.85) (103.543, 0.875) (106.8, 0.9) (110.358, 0.925) (114.267, 0.95) (118.575, 0.975) (123.333, 1) (128.602, 1.025) (134.479, 1.05) (141.076, 1.075) (148.5, 1.1) (156.909, 1.125) (166.646, 1.15) (178.102, 1.175) (191.667, 1.2) (207.922, 1.225) (228.208, 1.25) (254.057, 1.275) (287, 1.3) (329.26, 1.325) (385.833, 1.35) (462.406, 1.375) (564.667, 1.4) (698.927, 1.425) (874, 1.45) (1099.32, 1.475) (1384.33, 1.5) (1737.49, 1.525) (2163.38, 1.55) (2665.57, 1.575) (3247.67, 1.6) (3912.76, 1.625) (4661.94, 1.65) (5495.77, 1.675) (6414.83, 1.7) (7407.02, 1.72474) (8409.48, 1.74794) (9346.65, 1.76806) (10143, 1.78356) (10794.8, 1.79346) (11585.9, 1.79912) (12871.7, 1.80246) (15008, 1.80539) (18240.8, 1.80945) (22378, 1.81465) (27118.3, 1.82061) (32160, 1.82694)} conductivity=2380950 core_loss_type="Electrical Steel" core_loss_kh=182.455 core_loss_kc=1.34676 mass_density=7650
  copper: permeability=0.999991 conductivity=58000000
  M350-50A_20C: permeability{HUnit=A_per_meter BUnit=tesla curve (0, 0) (34.8, 0.1) (46, 0.2) (53.7, 0.3) (60.6, 0.4) (67.4, 0.5) (74.6, 0.6) (82.6, 0.7) (91.8, 0.8) (103, 0.9) (119, 1) (141, 1.1) (178, 1.2) (250, 1.3) (455, 1.4) (1180, 1.5) (3020, 1.6) (6100, 1.7) (10700, 1.8) (25000, 1.9) (35000, 1.956) (75000, 2.1) (115000, 2.2) (150000, 2.2701) (229580, 2.4)} conductivity=2272727.3 core_loss_type="Electrical Steel" core_loss_kh=159.9615 core_loss_kc=0.93462163 mass_density=7650 stacking_type=Lamination stacking_factor=0.97 stacking_direction=V(3)
surface materials:
  Steel-oxidised-surface

design Design01 (Maxwell 2D, Transient, XY geometry, model units mm)
options: ComputeTransientInductance ComputeIncrementalMatrix ModelDepth=StackLength
variables:
  Poles = 2*2
  SymmetryFactor = Poles
  Im = 6A
  epsI = 66.2673deg  # optimise 1rad..3rad
  Nper = 1/6
  DiaStatorGap = 79mm
  DiaStatorYoke = 125mm
  Airgap = 0.225mm
  SlotNumber = 36
  SlotType = 3
  DiaShaft = 25mm
  StackLength = 85mm
  Layers = 1
  ParallelPaths = 1
  CoilPitch = 9
  SlotLiner = 0.3mm
  SpaceLayers = 0.2mm
  Nc = 68
  Hs0 = 0.95mm
  Hs1 = 0.31mm
  Hs2 = 8.24mm
  Bs0 = 2.2mm
  Bs1 = 3.37mm
  Bs2 = 4.8mm
  Rs = 1.5mm
  SetAngle = 10deg
  ModelLength = 85mm
  StatorSkewAngle = 0deg
  InitPos = -30deg
  f = 50Hz
  RotSpeed = 1500rpm
  PointPer = 101
  HalfAxial = 0
  DiaOuter = 125mm
  SegAngle = 0deg
geometry:
  Region [vacuum] = circle(normal=Z, centre=(0mm, 0mm, 0mm), radius=DiaStatorYoke/2)
  Band [vacuum] = circle(normal=Z, centre=(0mm, 0mm, 0mm), radius=(DiaStatorGap - (1.0 * Airgap))/2)
  Shaft [vacuum] = circle(normal=Z, centre=(0mm, 0mm, 0mm), radius=DiaShaft/2)
  Stator [Cogent Power - M350-50A, B-H at 50Hz] = user_primitive(RMxprt/SlotCore.dll, DiaGap=DiaStatorGap, DiaYoke=DiaStatorYoke, Length=0mm, Skew=0deg, Slots=SlotNumber, SlotType=SlotType, Hs0=Hs0, Hs01=0mm, Hs1=Hs1, Hs2=Hs2, Bs0=Bs0, Bs1=Bs1, Bs2=Bs2, Rs=Rs, FilletType=0, HalfSlot=0, SegAngle=0deg, LenRegion=0mm, InfoCore=0)
  Coil [copper] = rectangle(corner=(DiaStatorGap/2+Hs0+Hs1+SlotLiner, -(Bs1/2-SlotLiner), 0mm), x_size=(Hs2+Rs/2-2*SlotLiner)/Layers-(Layers-1)*SpaceLayers/2, y_size=Bs1-2*SlotLiner)
  Coil.rotate(axis=Z, angle=360deg/SlotNumber/2)
  Coil_1..Coil_8 [copper] = Coil.duplicate_around_axis(axis=Z, angle=360deg/SlotNumber, total=CoilPitch)
  coordinate_system Section = origin=(0mm, 0mm, 0mm) x=(cos(360deg/SymmetryFactor), sin(360deg/SymmetryFactor), 0mm) y=(-sin(360deg/SymmetryFactor), cos(360deg/SymmetryFactor), 0mm)
  [Stator, Shaft, Region, Band].split(plane=ZX, keep=NegativeOnly) in Section
  [Stator, Shaft, Region, Band].split(plane=ZX, keep=PositiveOnly)
  Rotor_1 [M350-50A_20C] = circle(normal=Z, centre=(0mm, 0mm, 0mm), radius=39.275mm)
  Rotor_Subtract_10 = circle(normal=Z, centre=(0mm, 0mm, 0mm), radius=12.5mm)
  Rotor_1.subtract(Rotor_Subtract_10)
  Band_Tool = user_primitive(RMxprt/Band.dll, DiaGap=1mm, DiaYoke=DiaOuter, Length=0mm, SegAngle=SegAngle, Fractions=SymmetryFactor, HalfAxial=HalfAxial, InfoCore=1)
  Band_Tool_2 = Band_Tool.copy()
  Rotor_1.subtract(Band_Tool_2)
  Rotor_Pocket_10 = polyline(z=0mm, xy in mm: (30.8156, 18.1161) (33.8578, 17.85) (33.5733, 18.3794) (33.2806, 18.9043) (32.8151, 18.945) (26.1629, 25.5972) (24.7487, 24.183) (30.8156, 18.1161), closed, covered, Arc from point 1 over 3)
  Band_Tool_14 = Band_Tool.copy()
  Rotor_Pocket_10.subtract(Band_Tool_14)
  Rotor_Pocket_13 = polyline(z=0mm, xy in mm: (29.571, 13.5624) (35.9996, 13) (35.7074, 13.7824) (35.3981, 14.5583) (30.4006, 14.9955) (22.9809, 22.4152) (21.8495, 21.2839) (29.571, 13.5624), closed, covered, Arc from point 1 over 3)
  Band_Tool_17 = Band_Tool.copy()
  Rotor_Pocket_13.subtract(Band_Tool_17)
  Rotor_Pocket_15 = polyline(z=0mm, xy in mm: (18.1161, 30.8156) (24.183, 24.7487) (25.5972, 26.1629) (18.945, 32.8151) (18.9043, 33.2806) (18.3794, 33.5733) (17.85, 33.8578) (18.1161, 30.8156), closed, covered, Arc from point 4 over 3)
  Band_Tool_19 = Band_Tool.copy()
  Rotor_Pocket_15.subtract(Band_Tool_19)
  Rotor_Pocket_19 = polyline(z=0mm, xy in mm: (26.1525, 8.4956) (37.5329, 7.5) (37.348, 8.3725) (37.1427, 9.2406) (27.847, 10.0539) (19.2333, 18.6676) (17.6069, 17.0412) (26.1525, 8.4956), closed, covered, Arc from point 1 over 3)
  Band_Tool_23 = Band_Tool.copy()
  Rotor_Pocket_19.subtract(Band_Tool_23)
  Rotor_Pocket_21 = polyline(z=0mm, xy in mm: (13.5624, 29.571) (21.2839, 21.8495) (22.4152, 22.9809) (14.9955, 30.4006) (14.5583, 35.3981) (13.7824, 35.7074) (13, 35.9996) (13.5624, 29.571), closed, covered, Arc from point 4 over 3)
  Band_Tool_25 = Band_Tool.copy()
  Rotor_Pocket_21.subtract(Band_Tool_25)
  Rotor_Pocket_25 = polyline(z=0mm, xy in mm: (20.3523, 3.3145) (38.2349, 1.75) (38.156, 3.0151) (38.0352, 4.277) (22.2515, 5.6579) (14.2375, 13.6719) (12.1162, 11.5505) (20.3523, 3.3145), closed, covered, Arc from point 1 over 3)
  Band_Tool_29 = Band_Tool.copy()
  Rotor_Pocket_25.subtract(Band_Tool_29)
  Rotor_Pocket_27 = polyline(z=0mm, xy in mm: (8.4956, 26.1525) (17.0412, 17.6069) (18.6676, 19.2333) (10.0539, 27.847) (9.2406, 37.1427) (8.3725, 37.348) (7.4999, 37.5329) (8.4956, 26.1525), closed, covered, Arc from point 4 over 3)
  Band_Tool_31 = Band_Tool.copy()
  Rotor_Pocket_27.subtract(Band_Tool_31)
  Rotor_Pocket_30 = polyline(z=0mm, xy in mm: (3.3145, 20.3523) (11.5505, 12.1162) (13.6719, 14.2375) (5.6579, 22.2515) (4.277, 38.0352) (3.0151, 38.156) (1.75, 38.2349) (3.3145, 20.3523), closed, covered, Arc from point 4 over 3)
  Band_Tool_34 = Band_Tool.copy()
  Rotor_Pocket_30.subtract(Band_Tool_34)
  RotorDuctFluidRegion_1 = polyline(z=0mm, xy in mm: (-2.4677, 16.6099) (-1.8168, 15.7505) (-0.7638, 15.9817) (-0.382, 15.9954) (0, 16) (0.382, 15.9954) (0.7638, 15.9817) (1.8168, 15.7505) (2.4677, 16.6099) (2.8048, 16.9469) (2.7718, 17.4182) (2.5261, 17.8218) (1.2661, 17.9554) (0, 18) (-1.2661, 17.9554) (-2.5261, 17.8218) (-2.7718, 17.4182) (-2.8048, 16.9469) (-2.4677, 16.6099), closed, covered, Arc from point 0 over 3, Arc from point 2 over 3, Arc from point 4 over 3, Arc from point 6 over 3, Arc from point 9 over 3, Arc from point 11 over 3, Arc from point 13 over 3, Arc from point 15 over 3)
  Band_Tool_36 = Band_Tool.copy()
  RotorDuctFluidRegion_1.subtract(Band_Tool_36)
  RotorDuctFluidRegion_3 = polyline(z=0mm, xy in mm: (15.9817, -0.7638) (15.7505, -1.8168) (16.6099, -2.4677) (16.9469, -2.8048) (17.4182, -2.7718) (17.8218, -2.5261) (17.9554, -1.2661) (18, 0) (17.9554, 1.2661) (17.8218, 2.5261) (17.4182, 2.7718) (16.9469, 2.8048) (16.6099, 2.4677) (15.7505, 1.8168) (15.9817, 0.7638) (15.9954, 0.382) (16, 0) (15.9954, -0.382) (15.9817, -0.7638), closed, covered, Arc from point 0 over 3, Arc from point 3 over 3, Arc from point 5 over 3, Arc from point 7 over 3, Arc from point 9 over 3, Arc from point 12 over 3, Arc from point 14 over 3, Arc from point 16 over 3)
  Band_Tool_38 = Band_Tool.copy()
  RotorDuctFluidRegion_3.subtract(Band_Tool_38)
  Rotor_1.subtract(Rotor_Pocket_10, Rotor_Pocket_13, Rotor_Pocket_15, Rotor_Pocket_19, Rotor_Pocket_21, Rotor_Pocket_25, Rotor_Pocket_27, Rotor_Pocket_30, RotorDuctFluidRegion_1, RotorDuctFluidRegion_3)
  Band_Tool.delete()
motion:
  MotionSetup1: Band Move_Type=Rotate Coordinate_System=Global Axis=Z Is_Positive=true InitPos=InitPos Angular_Velocity=RotSpeed Objects=Band
  Moving1: Moving Objects=[Shaft, Rotor_1]
boundaries and excitations:
  Symmetry: Independent Edges=Region.edge(at (31.25, 0, 0)) ReverseV
  Symmetry_dep: Dependent Edges=Region.edge(at (0, 31.25, 0)) Independent=Symmetry RelationIsSame=false
  A0: Vector Potential Edges=Region.edge(at (44.1942, 44.1942, 0)) Value=0
  CS1: Coil Objects=Coil Conductor_number=Nc Winding=PhaseA PolarityType=Positive
  CS2: Coil Objects=Coil_1 Conductor_number=Nc Winding=PhaseA PolarityType=Positive
  CS3: Coil Objects=Coil_2 Conductor_number=Nc Winding=PhaseA PolarityType=Positive
  CS7: Coil Objects=Coil_6 Conductor_number=Nc Winding=PhaseB PolarityType=Positive
  CS8: Coil Objects=Coil_7 Conductor_number=Nc Winding=PhaseB PolarityType=Positive
  CS9: Coil Objects=Coil_8 Conductor_number=Nc Winding=PhaseB PolarityType=Positive
  CS4: Coil Objects=Coil_3 Conductor_number=Nc Winding=PhaseC PolarityType=Negative
  CS5: Coil Objects=Coil_4 Conductor_number=Nc Winding=PhaseC PolarityType=Negative
  CS6: Coil Objects=Coil_5 Conductor_number=Nc Winding=PhaseC PolarityType=Negative
  PhaseA: Winding Group Type=Current IsSolid=false Current="Im * cos(2*pi*f*time+epsI-pi)" ParallelBranchesNum=ParallelPaths
  PhaseB: Winding Group Type=Current IsSolid=false Current="Im * cos(2*pi*f*time-120deg+epsI-pi)" ParallelBranchesNum=ParallelPaths
  PhaseC: Winding Group Type=Current IsSolid=false Current="Im * cos(2*pi*f*time-240deg+epsI-pi)" ParallelBranchesNum=ParallelPaths
mesh:
  CylindricalGap1: CylindricalGap Objects=Band Objects=Band
  coils: LengthBased RefineInside Objects=[Coil, Coil_1..Coil_8] MaxLength=3mm
  stator: LengthBased RefineInside Objects=Stator MaxLength=3mm
  Rotor: LengthBased RefineInside Objects=Rotor_1 MaxLength=3mm
  Stator: LengthBased Objects=Stator MaxLength=3mm
setups:
  Setup1: Transient NonlinearSolverResidual=0.005 ScalarPotential="Second Order" StopTime=Nper/f TimeStep=1/(f*(PointPer-1)) OutputError OutputPerObjectCoreLoss OutputPerObjectSolidLoss InitialTimeStep=0.002s MinTimeStep=0.001s MaxTimeStep=0.003s TimeStepErrTolerance=0.0001
optimetrics:
  ParametricSetup1: Parametric InterpolationPoints=0 Sim._Setups=[Setup1]
    sweep Im: LIN 1A 4A 1A
    calculate mean(Moving1.Torque) on Setup1 : Transient at Time all
    calculate mean(L_d) on Setup1 : Transient at Time all
    calculate mean(L_q) on Setup1 : Transient at Time all
    calculate mean(Flux_d) on Setup1 : Transient at Time all
    calculate mean(Flux_q) on Setup1 : Transient at Time all
  OptimizationSetup2: Optimization InterpolationPoints=0 Optimizer="DX NLPQL" AnalysisStopOptions{StopForNumIteration MaxNumIteration=40 MinNumIteration=10} CostFuncNormType=L2 PreSolvePSetup=false Acceptable_Cost=0 Noise=0.0001 UpdateDesignWhenDone
    vary epsI: Min=35deg Max=75deg MinStep=0.02rad MaxStep=0.2rad MinFocus=1rad MaxFocus=3rad start=45deg
    goal mean(Moving1.Torque) Maximize 0 weight 1 on Setup1 : Transient at Time all
output variables:
  PolePairs = 2
  RotSign = 1
  MechOffsetDeg = -30
  Rs = 1
  Lew = 1e-06
  theta_el = RotSign*(Moving1.Position - MechOffsetDeg/180*pi) * PolePairs - pi
  cos0_1 = cos(1*(theta_el - 2*PI*0/3))
  sin0_1 = sin(-1*(theta_el - 2*PI*0/3))
  cos1_1 = cos(1*(theta_el - 2*PI*1/3))
  sin1_1 = sin(-1*(theta_el - 2*PI*1/3))
  cos2_1 = cos(1*(theta_el - 2*PI*2/3))
  sin2_1 = sin(-1*(theta_el - 2*PI*2/3))
  Flux_d1 = (FluxLinkage(PhaseA)*cos0_1 + FluxLinkage(PhaseB)*cos1_1 + FluxLinkage(PhaseC)*cos2_1) * 2/3
  Flux_q1 = (FluxLinkage(PhaseA)*sin0_1 + FluxLinkage(PhaseB)*sin1_1 + FluxLinkage(PhaseC)*sin2_1) * 2/3
  Vind_d1 = (InducedVoltage(PhaseA)*cos0_1 + InducedVoltage(PhaseB)*cos1_1 + InducedVoltage(PhaseC)*cos2_1) * 2/3
  Vind_q1 = (InducedVoltage(PhaseA)*sin0_1 + InducedVoltage(PhaseB)*sin1_1 + InducedVoltage(PhaseC)*sin2_1) * 2/3
  V_A = InducedVoltage(PhaseA) + Rs*InputCurrent(PhaseA) + Lew*ddt(InputCurrent(PhaseA))
  V_B = InducedVoltage(PhaseB) + Rs*InputCurrent(PhaseB) + Lew*ddt(InputCurrent(PhaseB))
  V_C = InducedVoltage(PhaseC) + Rs*InputCurrent(PhaseC) + Lew*ddt(InputCurrent(PhaseC))
  V_AB = V_A - V_B
  V_BC = V_B - V_C
  V_CA = V_C - V_A
  Vterm_A = 1/3*(2*V_AB + 1*V_BC)
  Vterm_B = 1/3*(-1*V_AB + 1*V_BC)
  Vterm_C = 1/3*(-1*V_AB + -2*V_BC)
  I_d1 = (InputCurrent(PhaseA)*cos0_1 + InputCurrent(PhaseB)*cos1_1 + InputCurrent(PhaseC)*cos2_1) * 2/3
  I_q1 = (InputCurrent(PhaseA)*sin0_1 + InputCurrent(PhaseB)*sin1_1 + InputCurrent(PhaseC)*sin2_1) * 2/3
  V_d1 = (V_A*cos0_1 + V_B*cos1_1 + V_C*cos2_1) * 2/3
  V_q1 = (V_A*sin0_1 + V_B*sin1_1 + V_C*sin2_1) * 2/3
  L0d_1 = L(PhaseA,PhaseA)*cos0_1 + L(PhaseA,PhaseB)*cos1_1 + L(PhaseA,PhaseC)*cos2_1
  L0q_1 = L(PhaseA,PhaseA)*sin0_1 + L(PhaseA,PhaseB)*sin1_1 + L(PhaseA,PhaseC)*sin2_1
  L1d_1 = L(PhaseB,PhaseA)*cos0_1 + L(PhaseB,PhaseB)*cos1_1 + L(PhaseB,PhaseC)*cos2_1
  L1q_1 = L(PhaseB,PhaseA)*sin0_1 + L(PhaseB,PhaseB)*sin1_1 + L(PhaseB,PhaseC)*sin2_1
  L2d_1 = L(PhaseC,PhaseA)*cos0_1 + L(PhaseC,PhaseB)*cos1_1 + L(PhaseC,PhaseC)*cos2_1
  L2q_1 = L(PhaseC,PhaseA)*sin0_1 + L(PhaseC,PhaseB)*sin1_1 + L(PhaseC,PhaseC)*sin2_1
  Ld1 = (L0d_1*cos0_1 + L1d_1*cos1_1 + L2d_1*cos2_1) * 2/3
  Ld1q1 = (L0d_1*sin0_1 + L1d_1*sin1_1 + L2d_1*sin2_1) * 2/3
  Lq1d1 = (L0q_1*cos0_1 + L1q_1*cos1_1 + L2q_1*cos2_1) * 2/3
  Lq1 = (L0q_1*sin0_1 + L1q_1*sin1_1 + L2q_1*sin2_1) * 2/3
  Flux_e_d1 = Flux_d1 - (Ld1*I_d1 + Ld1q1*I_q1)
  Flux_e_q1 = Flux_q1 - (Lq1d1*I_d1 + Lq1*I_q1)
  Torque_dq = 3/2*PolePairs*(1*(Flux_d1*I_q1 - Flux_q1*I_d1))
reports:
  InducedVoltage: InducedVoltage(PhaseA), InducedVoltage(PhaseB), InducedVoltage(PhaseC) vs Time on Setup1 : Transient
  Current: InputCurrent(PhaseA), InputCurrent(PhaseB), InputCurrent(PhaseC) vs Time on Setup1 : Transient
  FluxLinkage: FluxLinkage(PhaseA), FluxLinkage(PhaseB), FluxLinkage(PhaseC) vs Time on Setup1 : Transient
  Current_dq: I_d1, I_q1 vs Time on Setup1 : Transient
  FluxLinkage_dq: Flux_d1, Flux_q1 vs Time on Setup1 : Transient
  InducedVoltage_dq: Ui_d, Ui_q vs Time on Setup1 : Transient
  Inductance_dq: Ld1, Lq1 vs Time on Setup1 : Transient
  Output Variables Plot 1: L_d vs Time on Setup1 : Transient
  Output Variables Plot 2: L_q vs Time on Setup1 : Transient
  Torque Plot 1: Moving1.Torque vs Time on Setup1 : Transient

design Design02_def_Idq (Maxwell 2D, Transient, XY geometry, model units mm)
options: ComputeTransientInductance ComputeIncrementalMatrix ModelDepth=StackLength
variables:
  Poles = 2*2
  SymmetryFactor = Poles
  Im = sqrt(Id^2+Iq^2)
  epsI = atan2(Iq,Id)
  Nper = 1/6
  Id = 2.4A
  Iq = 5.5A
  DiaStatorGap = 79mm
  DiaStatorYoke = 125mm
  Airgap = 0.225mm
  SlotNumber = 36
  SlotType = 3
  DiaShaft = 25mm
  StackLength = 85mm
  Layers = 1
  ParallelPaths = 1
  CoilPitch = 9
  SlotLiner = 0.3mm
  SpaceLayers = 0.2mm
  Nc = 68
  Hs0 = 0.95mm
  Hs1 = 0.31mm
  Hs2 = 8.24mm
  Bs0 = 2.2mm
  Bs1 = 3.37mm
  Bs2 = 4.8mm
  Rs = 1.5mm
  SetAngle = 10deg
  ModelLength = 85mm
  StatorSkewAngle = 0deg
  InitPos = -30deg
  f = 50Hz
  RotSpeed = 1500rpm
  PointPer = 101
  HalfAxial = 0
  DiaOuter = 125mm
  SegAngle = 0deg
geometry:
  Region [vacuum] = circle(normal=Z, centre=(0mm, 0mm, 0mm), radius=DiaStatorYoke/2)
  Band [vacuum] = circle(normal=Z, centre=(0mm, 0mm, 0mm), radius=(DiaStatorGap - (1.0 * Airgap))/2)
  Shaft [vacuum] = circle(normal=Z, centre=(0mm, 0mm, 0mm), radius=DiaShaft/2)
  Stator [Cogent Power - M350-50A, B-H at 50Hz] = user_primitive(RMxprt/SlotCore.dll, DiaGap=DiaStatorGap, DiaYoke=DiaStatorYoke, Length=0mm, Skew=0deg, Slots=SlotNumber, SlotType=SlotType, Hs0=Hs0, Hs01=0mm, Hs1=Hs1, Hs2=Hs2, Bs0=Bs0, Bs1=Bs1, Bs2=Bs2, Rs=Rs, FilletType=0, HalfSlot=0, SegAngle=0deg, LenRegion=0mm, InfoCore=0)
  Coil [copper] = rectangle(corner=(DiaStatorGap/2+Hs0+Hs1+SlotLiner, -(Bs1/2-SlotLiner), 0mm), x_size=(Hs2+Rs/2-2*SlotLiner)/Layers-(Layers-1)*SpaceLayers/2, y_size=Bs1-2*SlotLiner)
  Coil.rotate(axis=Z, angle=360deg/SlotNumber/2)
  Coil_1..Coil_8 [copper] = Coil.duplicate_around_axis(axis=Z, angle=360deg/SlotNumber, total=CoilPitch)
  coordinate_system Section = origin=(0mm, 0mm, 0mm) x=(cos(360deg/SymmetryFactor), sin(360deg/SymmetryFactor), 0mm) y=(-sin(360deg/SymmetryFactor), cos(360deg/SymmetryFactor), 0mm)
  [Stator, Shaft, Region, Band].split(plane=ZX, keep=NegativeOnly) in Section
  [Stator, Shaft, Region, Band].split(plane=ZX, keep=PositiveOnly)
  Rotor_1 [M350-50A_20C] = circle(normal=Z, centre=(0mm, 0mm, 0mm), radius=39.275mm)
  Rotor_Subtract_10 = circle(normal=Z, centre=(0mm, 0mm, 0mm), radius=12.5mm)
  Rotor_1.subtract(Rotor_Subtract_10)
  Band_Tool = user_primitive(RMxprt/Band.dll, DiaGap=1mm, DiaYoke=DiaOuter, Length=0mm, SegAngle=SegAngle, Fractions=SymmetryFactor, HalfAxial=HalfAxial, InfoCore=1)
  Band_Tool_2 = Band_Tool.copy()
  Rotor_1.subtract(Band_Tool_2)
  Rotor_Pocket_10 = polyline(z=0mm, xy in mm: (30.8156, 18.1161) (33.8578, 17.85) (33.5733, 18.3794) (33.2806, 18.9043) (32.8151, 18.945) (26.1629, 25.5972) (24.7487, 24.183) (30.8156, 18.1161), closed, covered, Arc from point 1 over 3)
  Band_Tool_14 = Band_Tool.copy()
  Rotor_Pocket_10.subtract(Band_Tool_14)
  Rotor_Pocket_13 = polyline(z=0mm, xy in mm: (29.571, 13.5624) (35.9996, 13) (35.7074, 13.7824) (35.3981, 14.5583) (30.4006, 14.9955) (22.9809, 22.4152) (21.8495, 21.2839) (29.571, 13.5624), closed, covered, Arc from point 1 over 3)
  Band_Tool_17 = Band_Tool.copy()
  Rotor_Pocket_13.subtract(Band_Tool_17)
  Rotor_Pocket_15 = polyline(z=0mm, xy in mm: (18.1161, 30.8156) (24.183, 24.7487) (25.5972, 26.1629) (18.945, 32.8151) (18.9043, 33.2806) (18.3794, 33.5733) (17.85, 33.8578) (18.1161, 30.8156), closed, covered, Arc from point 4 over 3)
  Band_Tool_19 = Band_Tool.copy()
  Rotor_Pocket_15.subtract(Band_Tool_19)
  Rotor_Pocket_19 = polyline(z=0mm, xy in mm: (26.1525, 8.4956) (37.5329, 7.5) (37.348, 8.3725) (37.1427, 9.2406) (27.847, 10.0539) (19.2333, 18.6676) (17.6069, 17.0412) (26.1525, 8.4956), closed, covered, Arc from point 1 over 3)
  Band_Tool_23 = Band_Tool.copy()
  Rotor_Pocket_19.subtract(Band_Tool_23)
  Rotor_Pocket_21 = polyline(z=0mm, xy in mm: (13.5624, 29.571) (21.2839, 21.8495) (22.4152, 22.9809) (14.9955, 30.4006) (14.5583, 35.3981) (13.7824, 35.7074) (13, 35.9996) (13.5624, 29.571), closed, covered, Arc from point 4 over 3)
  Band_Tool_25 = Band_Tool.copy()
  Rotor_Pocket_21.subtract(Band_Tool_25)
  Rotor_Pocket_25 = polyline(z=0mm, xy in mm: (20.3523, 3.3145) (38.2349, 1.75) (38.156, 3.0151) (38.0352, 4.277) (22.2515, 5.6579) (14.2375, 13.6719) (12.1162, 11.5505) (20.3523, 3.3145), closed, covered, Arc from point 1 over 3)
  Band_Tool_29 = Band_Tool.copy()
  Rotor_Pocket_25.subtract(Band_Tool_29)
  Rotor_Pocket_27 = polyline(z=0mm, xy in mm: (8.4956, 26.1525) (17.0412, 17.6069) (18.6676, 19.2333) (10.0539, 27.847) (9.2406, 37.1427) (8.3725, 37.348) (7.4999, 37.5329) (8.4956, 26.1525), closed, covered, Arc from point 4 over 3)
  Band_Tool_31 = Band_Tool.copy()
  Rotor_Pocket_27.subtract(Band_Tool_31)
  Rotor_Pocket_30 = polyline(z=0mm, xy in mm: (3.3145, 20.3523) (11.5505, 12.1162) (13.6719, 14.2375) (5.6579, 22.2515) (4.277, 38.0352) (3.0151, 38.156) (1.75, 38.2349) (3.3145, 20.3523), closed, covered, Arc from point 4 over 3)
  Band_Tool_34 = Band_Tool.copy()
  Rotor_Pocket_30.subtract(Band_Tool_34)
  RotorDuctFluidRegion_1 = polyline(z=0mm, xy in mm: (-2.4677, 16.6099) (-1.8168, 15.7505) (-0.7638, 15.9817) (-0.382, 15.9954) (0, 16) (0.382, 15.9954) (0.7638, 15.9817) (1.8168, 15.7505) (2.4677, 16.6099) (2.8048, 16.9469) (2.7718, 17.4182) (2.5261, 17.8218) (1.2661, 17.9554) (0, 18) (-1.2661, 17.9554) (-2.5261, 17.8218) (-2.7718, 17.4182) (-2.8048, 16.9469) (-2.4677, 16.6099), closed, covered, Arc from point 0 over 3, Arc from point 2 over 3, Arc from point 4 over 3, Arc from point 6 over 3, Arc from point 9 over 3, Arc from point 11 over 3, Arc from point 13 over 3, Arc from point 15 over 3)
  Band_Tool_36 = Band_Tool.copy()
  RotorDuctFluidRegion_1.subtract(Band_Tool_36)
  RotorDuctFluidRegion_3 = polyline(z=0mm, xy in mm: (15.9817, -0.7638) (15.7505, -1.8168) (16.6099, -2.4677) (16.9469, -2.8048) (17.4182, -2.7718) (17.8218, -2.5261) (17.9554, -1.2661) (18, 0) (17.9554, 1.2661) (17.8218, 2.5261) (17.4182, 2.7718) (16.9469, 2.8048) (16.6099, 2.4677) (15.7505, 1.8168) (15.9817, 0.7638) (15.9954, 0.382) (16, 0) (15.9954, -0.382) (15.9817, -0.7638), closed, covered, Arc from point 0 over 3, Arc from point 3 over 3, Arc from point 5 over 3, Arc from point 7 over 3, Arc from point 9 over 3, Arc from point 12 over 3, Arc from point 14 over 3, Arc from point 16 over 3)
  Band_Tool_38 = Band_Tool.copy()
  RotorDuctFluidRegion_3.subtract(Band_Tool_38)
  Rotor_1.subtract(Rotor_Pocket_10, Rotor_Pocket_13, Rotor_Pocket_15, Rotor_Pocket_19, Rotor_Pocket_21, Rotor_Pocket_25, Rotor_Pocket_27, Rotor_Pocket_30, RotorDuctFluidRegion_1, RotorDuctFluidRegion_3)
  Band_Tool.delete()
motion:
  MotionSetup1: Band Move_Type=Rotate Coordinate_System=Global Axis=Z Is_Positive=true InitPos=InitPos Angular_Velocity=RotSpeed Objects=Band
  Moving1: Moving Objects=[Shaft, Rotor_1]
boundaries and excitations:
  Symmetry: Independent Edges=Region.edge(at (31.25, 0, 0)) ReverseV
  Symmetry_dep: Dependent Edges=Region.edge(at (0, 31.25, 0)) Independent=Symmetry RelationIsSame=false
  A0: Vector Potential Edges=Region.edge(at (44.1942, 44.1942, 0)) Value=0
  CS1: Coil Objects=Coil Conductor_number=Nc Winding=PhaseA PolarityType=Positive
  CS2: Coil Objects=Coil_1 Conductor_number=Nc Winding=PhaseA PolarityType=Positive
  CS3: Coil Objects=Coil_2 Conductor_number=Nc Winding=PhaseA PolarityType=Positive
  CS7: Coil Objects=Coil_6 Conductor_number=Nc Winding=PhaseB PolarityType=Positive
  CS8: Coil Objects=Coil_7 Conductor_number=Nc Winding=PhaseB PolarityType=Positive
  CS9: Coil Objects=Coil_8 Conductor_number=Nc Winding=PhaseB PolarityType=Positive
  CS4: Coil Objects=Coil_3 Conductor_number=Nc Winding=PhaseC PolarityType=Negative
  CS5: Coil Objects=Coil_4 Conductor_number=Nc Winding=PhaseC PolarityType=Negative
  CS6: Coil Objects=Coil_5 Conductor_number=Nc Winding=PhaseC PolarityType=Negative
  PhaseA: Winding Group Type=Current IsSolid=false Current="Im * cos(2*pi*f*time+epsI-pi)" ParallelBranchesNum=ParallelPaths
  PhaseB: Winding Group Type=Current IsSolid=false Current="Im * cos(2*pi*f*time-120deg+epsI-pi)" ParallelBranchesNum=ParallelPaths
  PhaseC: Winding Group Type=Current IsSolid=false Current="Im * cos(2*pi*f*time-240deg+epsI-pi)" ParallelBranchesNum=ParallelPaths
mesh:
  CylindricalGap1: CylindricalGap Objects=Band Objects=Band
  coils: LengthBased RefineInside Objects=[Coil, Coil_1..Coil_8] MaxLength=3mm
  stator: LengthBased RefineInside Objects=Stator MaxLength=3mm
  Rotor: LengthBased RefineInside Objects=Rotor_1 MaxLength=3mm
  Stator: LengthBased Objects=Stator MaxLength=3mm
setups:
  Setup1: Transient NonlinearSolverResidual=0.005 ScalarPotential="First Order" StopTime=Nper/f TimeStep=1/(f*(PointPer-1)) OutputError OutputPerObjectCoreLoss OutputPerObjectSolidLoss InitialTimeStep=0.002s MinTimeStep=0.001s MaxTimeStep=0.003s TimeStepErrTolerance=0.0001
optimetrics:
  ParametricSetup1: Parametric InterpolationPoints=0 Sim._Setups=[Setup1]
    sweep Id: LIN 0A 5A 0.2A
    sweep Iq: LIN 0A 5A 0.2A
    calculate mean(Moving1.Torque) on Setup1 : Transient at Time all
    calculate mean(Ld1) on Setup1 : Transient at Time all
    calculate mean(Lq1) on Setup1 : Transient at Time all
    calculate mean(Ld1q1) on Setup1 : Transient at Time all
    calculate mean(Lq1d1) on Setup1 : Transient at Time all
    calculate mean(Flux_d1) on Setup1 : Transient at Time all
    calculate mean(Flux_q1) on Setup1 : Transient at Time all
    calculate mean(Flux_e_d1) on Setup1 : Transient at Time all
    calculate mean(Flux_e_q1) on Setup1 : Transient at Time all
  OptimizationSetup2: Optimization InterpolationPoints=0 Optimizer="DX NLPQL" AnalysisStopOptions{StopForNumIteration MaxNumIteration=40 MinNumIteration=10} CostFuncNormType=L2 PreSolvePSetup=false Acceptable_Cost=0 Noise=0.0001 UpdateDesignWhenDone
    goal mean(Moving1.Torque) Maximize 0 weight 1 on Setup1 : Transient at Time all
output variables:
  PolePairs = 2
  RotSign = 1
  MechOffsetDeg = -30
  Rs = 1
  Lew = 1e-06
  theta_el = RotSign*(Moving1.Position - MechOffsetDeg/180*pi) * PolePairs - pi
  cos0_1 = cos(1*(theta_el - 2*PI*0/3))
  sin0_1 = sin(-1*(theta_el - 2*PI*0/3))
  cos1_1 = cos(1*(theta_el - 2*PI*1/3))
  sin1_1 = sin(-1*(theta_el - 2*PI*1/3))
  cos2_1 = cos(1*(theta_el - 2*PI*2/3))
  sin2_1 = sin(-1*(theta_el - 2*PI*2/3))
  Flux_d1 = (FluxLinkage(PhaseA)*cos0_1 + FluxLinkage(PhaseB)*cos1_1 + FluxLinkage(PhaseC)*cos2_1) * 2/3
  Flux_q1 = (FluxLinkage(PhaseA)*sin0_1 + FluxLinkage(PhaseB)*sin1_1 + FluxLinkage(PhaseC)*sin2_1) * 2/3
  Vind_d1 = (InducedVoltage(PhaseA)*cos0_1 + InducedVoltage(PhaseB)*cos1_1 + InducedVoltage(PhaseC)*cos2_1) * 2/3
  Vind_q1 = (InducedVoltage(PhaseA)*sin0_1 + InducedVoltage(PhaseB)*sin1_1 + InducedVoltage(PhaseC)*sin2_1) * 2/3
  V_A = InducedVoltage(PhaseA) + Rs*InputCurrent(PhaseA) + Lew*ddt(InputCurrent(PhaseA))
  V_B = InducedVoltage(PhaseB) + Rs*InputCurrent(PhaseB) + Lew*ddt(InputCurrent(PhaseB))
  V_C = InducedVoltage(PhaseC) + Rs*InputCurrent(PhaseC) + Lew*ddt(InputCurrent(PhaseC))
  V_AB = V_A - V_B
  V_BC = V_B - V_C
  V_CA = V_C - V_A
  Vterm_A = 1/3*(2*V_AB + 1*V_BC)
  Vterm_B = 1/3*(-1*V_AB + 1*V_BC)
  Vterm_C = 1/3*(-1*V_AB + -2*V_BC)
  I_d1 = (InputCurrent(PhaseA)*cos0_1 + InputCurrent(PhaseB)*cos1_1 + InputCurrent(PhaseC)*cos2_1) * 2/3
  I_q1 = (InputCurrent(PhaseA)*sin0_1 + InputCurrent(PhaseB)*sin1_1 + InputCurrent(PhaseC)*sin2_1) * 2/3
  V_d1 = (V_A*cos0_1 + V_B*cos1_1 + V_C*cos2_1) * 2/3
  V_q1 = (V_A*sin0_1 + V_B*sin1_1 + V_C*sin2_1) * 2/3
  L0d_1 = L(PhaseA,PhaseA)*cos0_1 + L(PhaseA,PhaseB)*cos1_1 + L(PhaseA,PhaseC)*cos2_1
  L0q_1 = L(PhaseA,PhaseA)*sin0_1 + L(PhaseA,PhaseB)*sin1_1 + L(PhaseA,PhaseC)*sin2_1
  L1d_1 = L(PhaseB,PhaseA)*cos0_1 + L(PhaseB,PhaseB)*cos1_1 + L(PhaseB,PhaseC)*cos2_1
  L1q_1 = L(PhaseB,PhaseA)*sin0_1 + L(PhaseB,PhaseB)*sin1_1 + L(PhaseB,PhaseC)*sin2_1
  L2d_1 = L(PhaseC,PhaseA)*cos0_1 + L(PhaseC,PhaseB)*cos1_1 + L(PhaseC,PhaseC)*cos2_1
  L2q_1 = L(PhaseC,PhaseA)*sin0_1 + L(PhaseC,PhaseB)*sin1_1 + L(PhaseC,PhaseC)*sin2_1
  Ld1 = (L0d_1*cos0_1 + L1d_1*cos1_1 + L2d_1*cos2_1) * 2/3
  Ld1q1 = (L0d_1*sin0_1 + L1d_1*sin1_1 + L2d_1*sin2_1) * 2/3
  Lq1d1 = (L0q_1*cos0_1 + L1q_1*cos1_1 + L2q_1*cos2_1) * 2/3
  Lq1 = (L0q_1*sin0_1 + L1q_1*sin1_1 + L2q_1*sin2_1) * 2/3
  Flux_e_d1 = Flux_d1 - (Ld1*I_d1 + Ld1q1*I_q1)
  Flux_e_q1 = Flux_q1 - (Lq1d1*I_d1 + Lq1*I_q1)
  Torque_dq = 3/2*PolePairs*(1*(Flux_d1*I_q1 - Flux_q1*I_d1))
reports:
  InducedVoltage: InducedVoltage(PhaseA), InducedVoltage(PhaseB), InducedVoltage(PhaseC) vs Time on Setup1 : Transient
  Current: InputCurrent(PhaseA), InputCurrent(PhaseB), InputCurrent(PhaseC) vs Time on Setup1 : Transient
  FluxLinkage: FluxLinkage(PhaseA), FluxLinkage(PhaseB), FluxLinkage(PhaseC) vs Time on Setup1 : Transient
  Current_dq: I_d1, I_q1 vs Time on Setup1 : Transient
  FluxLinkage_dq: Flux_d1, Flux_q1 vs Time on Setup1 : Transient
  Inductance_dq: Ld1, Lq1, Ld1q1, Lq1d1 vs Time on Setup1 : Transient
  Torque Plot 1: Moving1.Torque vs Time on Setup1 : Transient
